check quoted and long model versions

* (exec-spice "ngspice -b %s")

ix1  0 1       dc=5uA
mx1  1 1 0 0   nmos_plain l=5u w=5u

ix2  0 2       dc=5uA
mx2  2 2 0 0   nmos_quoted l=5u w=5u

ix3  0 3       dc=5uA
mx3  3 3 0 0   nmos_long l=5u w=5u

.model nmos_plain nmos ( version=3.2 level=8 )
.model nmos_quoted nmos ( version="3.2" level=8 )
.model nmos_long nmos ( version=3.2000000000000000000000000000000000000000000000000000000000000000000000000000000000000000000000000000000000000000000000000 level=8 )

.control

define mismatch(a,b,err) abs(a-b)>err

op

let fail_count = 0
let total_count = 2

if mismatch(v(2)/v(1), 1.0, 1e-4)
    let fail_count = fail_count + 1
end

if mismatch(v(3)/v(1), 1.0, 1e-4)
    let fail_count = fail_count + 1
end

if fail_count > 0
  echo "ERROR: $&fail_count of $&total_count tests failed"
  quit 1
else
  echo "INFO: success"
  quit 0
end

.endc

.end
