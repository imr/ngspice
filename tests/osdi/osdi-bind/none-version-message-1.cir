* osdi_bind: the messages of none and of a replaced binding name version=
*
* check.sh drops lines with Warning and Note, so the messages go to a file
* and print without their first word.

v1 a 0 1

.control
pre_osdi dummy_modules.osdi
osdi_bind mos 72 dummy_mos version=110
osdi_bind mos 72 none version=111 >& none-version-message-1.txt
osdi_bind mos 72 dummy_mos version=110 >>& none-version-message-1.txt
shell cut -d: -f2- none-version-message-1.txt
shell rm none-version-message-1.txt
op
.endc

.end
