* osdi_bind: polarity= rejects a missing parameter name, values that are not numbers, and a third value
*
* A rejected command adds no binding, so the listing is empty.

v1 a 0 1

.control
osdi_bind mos 70 dummy_modules.osdi:dummy_mos polarity=:1:0
osdi_bind mos 71 dummy_modules.osdi:dummy_mos polarity=type:a:b
osdi_bind mos 72 dummy_modules.osdi:dummy_mos polarity=type:1:0:5
osdi_bind
op
.endc

.end
