* osdi_bind: version= selects the module, polarity=<par>:<nval>:<pval>
*
* dummy_mos conducts g * type between drain and source (g = 1 mS),
* dummy_mos_alternate 2 mS. A 1 V source drives each case.
* Level 95: version=1 -> dummy_mos, version=2 -> dummy_mos_alternate,
* version=1 with nqs -> dummy_mos_alternate (two conditions win),
* anything else -> dummy_mos with type 3/-3 (the default binding).
* The dummy modules have no parameter version, so it is not passed on.

.model n_v1 nmos level=95 version=1
.model n_v1_3 nmos level=95 version="1.3"
.model n_v2 nmos level=95 version=2.0
.model n_v1_nqs nmos level=95 version=1 nqs=0
* 10 does not start with 1 followed by no digit: default
.model n_v10 nmos level=95 version=10
.model n_none nmos level=95
.model p_v1 pmos level=95 version=1
.model p_none pmos level=95
* polarity=type:1:0 as for BSIM-CMG 110: pmos sets type 0
.model n_110 nmos level=96 version=110
.model p_110 pmos level=96 version=110

v_n_v1 n_v1 0 1
m_n_v1 n_v1 0 0 0 n_v1
v_n_v1_3 n_v1_3 0 1
m_n_v1_3 n_v1_3 0 0 0 n_v1_3
v_n_v2 n_v2 0 1
m_n_v2 n_v2 0 0 0 n_v2
v_n_v1_nqs n_v1_nqs 0 1
m_n_v1_nqs n_v1_nqs 0 0 0 n_v1_nqs
v_n_v10 n_v10 0 1
m_n_v10 n_v10 0 0 0 n_v10
v_n_none n_none 0 1
m_n_none n_none 0 0 0 n_none
v_p_v1 p_v1 0 1
m_p_v1 p_v1 0 0 0 p_v1
v_p_none p_none 0 1
m_p_none p_none 0 0 0 p_none
v_n_110 n_110 0 1
m_n_110 n_110 0 0 0 n_110
v_p_110 p_110 0 1
m_p_110 p_110 0 0 0 p_110

.control
pre_osdi_bind mos 95 dummy_modules.osdi:dummy_mos version=1
pre_osdi_bind mos 95 dummy_modules.osdi:dummy_mos_alternate version=2
pre_osdi_bind mos 95 dummy_modules.osdi:dummy_mos_alternate version=1 has=nqs
pre_osdi_bind mos 95 dummy_modules.osdi:dummy_mos polarity=type:3:-3
pre_osdi_bind mos 96 dummy_modules.osdi:dummy_mos version=110 polarity=type:1:0
op
print i(v_n_v1) i(v_n_v1_3) i(v_n_v2) i(v_n_v1_nqs)
print i(v_n_v10) i(v_n_none) i(v_p_v1) i(v_p_none)
print i(v_n_110) i(v_p_110)
osdi_bind
osdi_bind mos 95 none version=1 has=nqs
osdi_bind mos 95 none version=2
osdi_bind
.endc

.end
