* osdi_bind: quoted alias= and ignore= values work as unquoted ones
*
* dummy_mos conducts g * area from drain to source (g = 1 mS).
* ab is an alias of area, and the module has no parameter xx.

.model mos_quoted_alias nmos level=70
.model mos_quoted_ignore nmos level=71 xx=5

v_quoted_alias quoted_alias 0 1
m_quoted_alias quoted_alias 0 0 0 mos_quoted_alias ab=2
v_quoted_ignore quoted_ignore 0 1
m_quoted_ignore quoted_ignore 0 0 0 mos_quoted_ignore

.control
pre_osdi_bind mos 70 dummy_modules.osdi:dummy_mos alias="ab:area"
pre_osdi_bind mos 71 dummy_modules.osdi:dummy_mos ignore="xx"
op
print i(v_quoted_alias) i(v_quoted_ignore)
osdi_bind
.endc

.end
