* osdi_bind: polarity= rejects values with none, and nan as a value
*
* A rejected command adds no binding, so the listing is empty.

v1 a 0 1

.control
osdi_bind mos 70 dummy_modules.osdi:dummy_mos polarity=none:1:0
osdi_bind mos 71 dummy_modules.osdi:dummy_mos polarity=type:nan:1
osdi_bind
op
.endc

.end
