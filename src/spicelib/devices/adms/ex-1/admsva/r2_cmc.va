//
// simple capacitor model
// t     R       i    C      b
// o——/\/\/——o——| |——o
//

`include "constants.h"
`include "discipline.h"

`define P_CELCIUS0 273.15
`define TNOM (`P_CELCIUS0 + 27.0)

module r2_cmc(t, b);
   inout t, b;
   electrical t, b;
   electrical i;
   branch (t, i) R;
   branch (i, b) C;
   parameter real w = 1u from (0.1u : +inf);
   parameter real l = 1u from (0.1u : +inf);
   parameter real nc = 1 from [1:2];
   parameter real rsh = 1 from (0 : +inf);
   parameter real ca = 1f from (0 : +inf);
   parameter real tcr = 0;
   parameter real vc1 = 0;
   parameter real vc2 = 0;
   parameter real type = 0; // 0=n, 1=p
   real dT, rsh_t, c, r, Ir, Qc, Ceff, pwrR;
   analog begin : L
       if ($port_connected(b) == 0)
          $finish(113);
       if ($param_given(tcr))
          $finish(4);
       if ($param_given(tcr))
          $finish(4);
       if (nc > 2)
          $finish(0);
       begin : initializeModel
          dT = $temperature - `TNOM;
          rsh_t = rsh*(1.0+tcr*dT);
       end
       begin : initializeInstance
          c = w*l*ca*1e12; // unit conversion
          if (nc > 1.5)
            r = rsh_t*(w/l)/12;
          else
            r = rsh_t*(w/l)/3;
       end
       begin : evaluateStatic
          Ir = V(R)/r;
       end
       begin : evaluateDynamic
          if (type > 0.5) // inelegant
            Qc = c*V(C)*(1-V(C)*(vc1/2-V(C)*vc2/3));
          else
            Qc = c*V(C)*(1+V(C)*(vc1/2+V(C)*vc2/3));
       end
       begin : loadStatic
          I(R) <+ Ir;
       end
       begin : loadDynamic
          I(C) <+ ddt(Qc);
       end
      begin : postProcess
         if (type > 0.5)
           Ceff = c*(1.0-V(C)*(vc1/2-V(C)/3));//error!
         else
           Ceff = c*(1.0+V(C)*(vc1/2+V(C)/3));//error!
         pwrR = V(R)*Ir;
      end
   end // analog
endmodule
