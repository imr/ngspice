`include "constants.vams"
`include "disciplines.vams"

module r2_cmc(d, s);
   inout     d, s;

   electrical d, s;

   real      Taa, Txx;

   analog begin

      Taa = 0;

      // Txx = 0;
      Txx = Taa;

      Taa = V(d,s);

      Taa = Txx;
      Taa = 0;

      I(d,s) <+ Taa;
   end

endmodule
