//======================================================================================
//======================================================================================
// Filename: psp102.va
//======================================================================================
//======================================================================================
//
//  (c) Copyright 2007, All Rights Reserved, NXP Semiconductors
//
//
//  Version: 102.1, April 2007 (Simkit 2.5)
//
//======================================================================================
//======================================================================================
//
// Further information can be found in the file readme.txt
//

`include "discipline.h"

`include "SIMKIT_macrodefs.include"

`include "JUNCAP200_macrodefs.include"

`include "PSP102_macrodefs.include"

/////////////////////////////////////////////////////////////////////////////
//
//  PSP global model code
//
/////////////////////////////////////////////////////////////////////////////

// `undef LocalModel
// `define Binning

module PSP102VA(D, G, S, B);

//`P(
//  info = "PSP MOSFET Model"
//  version = `VERS
//  revision = `VREV
//  simkit:name = "psp1020"
//  simkit:desc = "psp_1020"
//)

`include "PSP102_module.include"

endmodule
