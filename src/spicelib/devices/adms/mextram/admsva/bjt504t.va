`include "frontdef.inc"
`define SELFHEATING
`define SUBSTRATE

module bjt504tva (c, b, e, s, dt);

  // External ports
     inout c, b, e, s, dt;

     (*info="external collector node"*) electrical 	c;
     (*info="external base node"*) electrical 	b;
     (*info="external emitter node"*) electrical 	e;
     (*info="external substrate node"*) electrical 	s;
     (*info="external thermal node"*) electrical 	dt;

  // Internal nodes
     (*info="internal collector node 1"*) electrical 	c1;
     (*info="internal emitter node"*) electrical 	e1;
     (*info="internal base node 1"*) electrical 	b1;
     (*info="internal base node 2"*) electrical 	b2;
     (*info="internal collector node 2"*) electrical 	c2;
     (*info="internal collector node 3"*) electrical 	c3;
     (*info="internal collector node 4"*) electrical 	c4;
  // For correlated noise implementation
     (*info="internal noise node"*) electrical 	noi;

`include "parameters.inc"
`include "variables.inc"
`include "opvars.inc"

analog begin

`include "initialize.inc"
`include "tscaling.inc"
`include "evaluate.inc"
`include "opinfo.inc"

end  // analog
endmodule
