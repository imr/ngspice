`include "frontdef.inc"
`define SUBSTRATE

module bjt504_va (c, b, e, s);

`ifdef insideADMS
  `define P(p) (*p*)
`else
  `define P(p)
`endif

  // External ports
     inout c, b, e, s;

     electrical 	c     `P(info="external collector node");
     electrical 	b     `P(info="external base node");
     electrical 	e     `P(info="external emitter node");
     electrical 	s     `P(info="external substrate node");

  // Internal nodes
     electrical 	c1    `P(info="internal collector node 1");
     electrical 	e1    `P(info="internal emitter node");
     electrical 	b1    `P(info="internal base node 1");
     electrical 	b2    `P(info="internal base node 2");
     electrical 	c2    `P(info="internal collector node 2");
  // For correlated noise implementation
     electrical 	noi   `P(info="internal noise node");

`include "parameters.inc"
`include "variables.inc"

analog begin

`ifdef insideADMS
   @(initial_model) begin
`else
   @(initial_step or initial_step("static")) begin
`endif

`include "initialize.inc"
`include "tscaling.inc"

   end // initial_step

`include "evaluate.inc"

end  // analog
endmodule
