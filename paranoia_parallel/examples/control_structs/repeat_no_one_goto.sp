Test sequences for ngspice control structure got

.control

  goto starthere
  echo this not
*  label starthere
  echo done

  quit
.endc
