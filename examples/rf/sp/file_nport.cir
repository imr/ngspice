Example circuit to read a Touchstone-format parameter file.

* This file contains an an analog filter circuit; SP and AC analyses are run
* and the S-parameters are saved in a file.
* It also uses vector fitting for a *.nport file serving the nport instance
* in a circuit that reproduces the original from its saved S-parameters.
* Results from the two versions are plotted together for comparison.

* Derived from: Qucs 1.0.2 C:/Users/Tom Hajjar/.qucs - S/S-parameter_files_ngspice_prj/137MHz_BPF.sch

* Original circuit for SP analysis

VP2 filter_out 0 dc 0 ac 0.316228 SIN(0 0.316228 1G) portnum 2 z0 50
VP1 _net1 0 dc 0 ac 0.316228 SIN(0 0.316228 1G) portnum 1 z0 50
C1 _net2 _net1  4.7P
C5 _net3 filter_out  4.7P
C3 _net3 _net2  1P
C4 _net3 0  15P
C2 0 _net2  15P
L2 0 _net3  66N
L1 0 _net2  66N

* A version fitted from extracted s-parameters using the nport

VP4 net2 0 dc 0 ac 0.316228 ; Same as VP1 but that must not be loaded.
ri2 net2 sin2 50
N1 sin2 np_model_out 0 mymodel
.model mymodel nport(file="137mhz_bpf.nport")
ro2 np_model_out 0 50

* Control section, run simulations.

.control
* Run an SP analysis, derive group delay, write a Touchstone file
* Use this Touchstone file for vector fitting by pre_snp, thus get a file
* new_137MHz_BPF.nport
*SP LIN 71 107MEG 167MEG
*let Group_Delay = -1*deriv(cph(S_2_1))/(2*pi)
*wrs2p  $inputdir/new_137mhz_bpf.s2p
pre_snp -native $inputdir/137mhz_bpf.s2p

* Now run AC analysis

alter vp2 ac = 0
AC LIN 71 107MEG 167MEG
set xbrushwidth=2
display
plot group_delay(filter_out) sp1.Group_Delay group_delay(np_model_out)
plot db(filter_out) cph(filter_out) db(np_model_out) cph(np_model_out)
.endc

.END
