Hartley's Oscillator Circuit
* Hartley is an harmonic oscillator (LC based) which use
* an inductive partition of resonator to feed the single
* active device. Output is taken on node n2.
* Prediceted frequency is about 121.176 Hz.

* Models:
.model qnl npn(level=1 bf=80 rb=100 ccs=2pf tf=0.3ns tr=6ns cje=3pf cjc=2pf va=50)

vcc 	1 0 	5 pwl 0 0 1e-5 5
r1	1 n2	0.2k
q1	n2 3 0	qnl
c1	3 4	633n
l1	3 0	1.5
l2	0 4	500m
r2	4 n2	100

.control
set xbrushwidth=2
tran 10u 1
rusage time
plot v(n2) xlimit 0 100m
linearize v(n2) np=65536
fft v(n2)
plot mag(V(n2)) xlimit 0 500 ylimit 0 1.5
reset
* gfreq tstab oscnob psspoints harms sciter steadycoeff
pss 120 100e-3 n2 1024 11 10 5e-3
rusage
setplot pss1
plot v(n2) xlimit 0 500 ylimit 0 1.5
setplot pss2
plot v(n2)
.endc
