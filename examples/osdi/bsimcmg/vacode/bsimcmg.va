// ****************************************************************************
// *  BSIM-CMG 111.0.0 released by Harshit Agarwal on 09/12/2019              *
// *  BSIM Common Multi-Gate Model (Verilog-A)                                *
// ****************************************************************************

// ****************************************************************************
// *  Copyright © 2019 University of California                               *
// *                                                                          *
// *  Project director: Prof. Chenming Hu                                     *
// *                                                                          *
// *  Current developers: Harshit Agarwal (Postdoc)                           *
// *                      Pragya Kushwaha (Postdoc)                           *
// *                      Avirup Dasgupta (Postdoc)                           *
// *                      Yen-Kai Lin (Ph.D. student)                         *
// *                      Ming-Yen Kao (Ph.D. student)                        *
// ****************************************************************************

/*
Licensed under Educational Community License, Version 2.0 (the "License"); you may
not use this file except in compliance with the License. You may obtain a copy of the license at
http://opensource.org/licenses/ECL-2.0
Unless required by applicable law or agreed to in writing, software distributed under the License is distributed on an "AS IS" BASIS, WITHOUT
WARRANTIES OR CONDITIONS OF ANY KIND, either express or implied. See the License for the specific language governing permissions and limitations
under the License.

BSIM-CMG model is supported by the members of Silicon Integration Initiative's Compact Model Coalition. A link to the most recent version of this
standard can be found at: http://www.si2.org/cmc
*/

`include "constants.vams"
`include "disciplines.vams"
`include "bsimcmg_macros.include"
module bsimcmg_va(d, g, s, e, t);
    inout d, g, s, e, t;
    electrical d, g, s, e;
    electrical di, si;
    electrical ge, gi;
    electrical q;
    electrical n;
    thermal t;
    `include "bsimcmg_parameters.include"
    `include "bsimcmg_variables.include"
    `include "bsimcmg_body.include"
endmodule
